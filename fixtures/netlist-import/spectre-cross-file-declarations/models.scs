simulator lang=spectre
model nch bsim3v3 type=n
