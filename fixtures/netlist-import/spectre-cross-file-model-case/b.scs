simulator lang=spectre
model NCH bsim3v3 type=n
