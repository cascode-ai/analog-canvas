simulator lang=spectre
include "lib.scs" section=tt
subckt top d g s b
M1 (d g s b) nch w=1u l=30n
ends top
