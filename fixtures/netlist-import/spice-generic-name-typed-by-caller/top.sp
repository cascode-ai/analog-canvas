* named NMOS
.subckt top d g s b
M1 d g s b NMOS w=1u l=30n
.ends top
