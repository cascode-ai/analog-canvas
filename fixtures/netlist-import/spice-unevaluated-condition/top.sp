* conditional
R0 a 0 1k
.if missing_flag
R1 a 0 1k
.else
R2 a 0 2k
.endif
.end
