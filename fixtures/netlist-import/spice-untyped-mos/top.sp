* untyped
.subckt top d g s b
M1 d g s b nch_mac w=1u l=30n
.ends top
