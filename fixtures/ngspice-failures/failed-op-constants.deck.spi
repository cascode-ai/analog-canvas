* failed operating point, constants written
V1 vg 0 1
V2 vg 0 2
R1 vg 0 1k
.control
op
setplot const
set filetype=ascii
write failed-op-constants.raw
.endc
.end
