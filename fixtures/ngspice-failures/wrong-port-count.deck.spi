* wrong port count
.subckt scint VDD VSS Vin Vout phi1 phi2
R1 Vin Vout 1k
.ends scint
VDD vdd 0 1.8
XDUT vdd 0 vin vout phi1 scint
.control
op
set filetype=ascii
write wrong-port-count.raw
.endc
.end
