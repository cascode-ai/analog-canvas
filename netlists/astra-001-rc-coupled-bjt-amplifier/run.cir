RC-coupled BJT amplifier — functional verification
.include "circuit.spice"
.include "models.spice"
VCC vcc 0 12
VIN in 0 DC 0 AC 1 SIN(0 1m 1k)
XDUT vcc 0 in out astra_001_rc_coupled_bjt_amplifier
.temp 27
* @spec gain_1khz range 50 58 unit=dB
* @spec out_pp range 0.9 1.2 unit=V
* @spec supply_avg range -0.0032 -0.0023 unit=A
.control
set filetype=ascii
set appendwrite
set wr_singlescale
set wr_vecnames
op
print v(xdut.c1) v(xdut.c2) v(xdut.e1) v(xdut.e2) i(vcc)
ac dec 80 1 100Meg
let gain=db(v(out))
meas ac gain_1khz FIND gain AT=1000
wrdata ac.dat v(out)
write out.raw v(out)
tran 1u 30m
meas tran out_pp PP v(out) FROM=20m TO=30m
meas tran supply_avg AVG i(vcc) FROM=20m TO=30m
wrdata transient.dat v(in) v(out)
write out.raw v(in) v(out)
quit
.endc
.end
