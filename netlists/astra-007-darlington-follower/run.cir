Darlington emitter-follower buffer — nominal functional verification
.include "circuit.spice"
.include "models.spice"
VCC vcc 0 12
VIN in 0 DC 0 AC 1 SIN(0 100m 1k)
XDUT vcc 0 in out astra_007_darlington_follower
.temp 27
* @spec gain_1khz range -1.5 0 unit=dB
* @spec out_pp range 0.16 0.205 unit=V
* @spec supply_avg range 0.004 0.009 unit=A
.control
set filetype=ascii
set appendwrite
set wr_singlescale
set wr_vecnames
op
print v(out) i(vcc)
ac dec 80 1 100Meg
let gain=db(v(out))
meas ac gain_1khz FIND gain AT=1000
wrdata ac.dat v(out)
write out.raw v(out)
tran 2u 30m
let supply=-i(vcc)
meas tran out_pp PP v(out) FROM=20m TO=30m
meas tran supply_avg AVG supply FROM=20m TO=30m
wrdata transient.dat v(in) v(out)
write out.raw v(in) v(out)
quit
.endc
.end
