CMOS Muller C-element
.include "circuit.spice"
.include "models.spice"
VDD vdd 0 3.3
VA a 0 PWL(0 0 1n 0.0 40n 0.0 41n 3.3 80n 3.3 81n 0.0 120n 0.0 121n 0.0 160n 0.0 161n 3.3 200n 3.3 201n 0.0 240n 0.0 241n 3.3 280n 3.3 281n 3.3 320n 3.3 321n 0.0 360n 0.0)
VB b 0 PWL(0 0 1n 0.0 40n 0.0 41n 0.0 80n 0.0 81n 0.0 120n 0.0 121n 3.3 160n 3.3 161n 3.3 200n 3.3 201n 3.3 240n 3.3 241n 3.3 280n 3.3 281n 0.0 320n 0.0 321n 0.0 360n 0.0)
XDUT vdd 0 a b q astra_023_cmos_muller_c_element
.temp 27
.options method=gear reltol=1e-5
* @spec state0 range -0.01 0.01 unit=V
* @spec state1 range -0.01 0.01 unit=V
* @spec state2 range -0.01 0.01 unit=V
* @spec state3 range -0.01 0.01 unit=V
* @spec state4 range 3.2 3.4 unit=V
* @spec state5 range 3.2 3.4 unit=V
* @spec state6 range 3.2 3.4 unit=V
* @spec state7 range 3.2 3.4 unit=V
* @spec state8 range -0.01 0.01 unit=V
.control
set filetype=ascii
tran 20p 360n
meas tran state0 FIND v(q) AT=30n
meas tran state1 FIND v(q) AT=70n
meas tran state2 FIND v(q) AT=110n
meas tran state3 FIND v(q) AT=150n
meas tran state4 FIND v(q) AT=190n
meas tran state5 FIND v(q) AT=230n
meas tran state6 FIND v(q) AT=270n
meas tran state7 FIND v(q) AT=310n
meas tran state8 FIND v(q) AT=350n
write out.raw
quit
.endc
.end
