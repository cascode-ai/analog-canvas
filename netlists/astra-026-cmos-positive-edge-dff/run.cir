CMOS positive-edge D flip-flop
.include "circuit.spice"
.include "models.spice"
VDD vdd 0 3.3
VCLK clk 0 PULSE(0 3.3 20n 100p 100p 19.9n 40n)
VD d 0 PWL(0 0 12n 0 12.1n 3.3 28n 3.3 28.1n 0 70n 0 70.1n 3.3 110n 3.3 110.1n 0 152n 0 152.1n 3.3 210n 3.3)
XDUT vdd 0 d q clk astra_026_cmos_positive_edge_dff
.temp 27
.options method=gear reltol=1e-5
* @spec capture1 range 3.2 3.4 unit=V
* @spec hold1 range 3.2 3.4 unit=V
* @spec capture0 range -0.01 0.01 unit=V
* @spec hold0 range -0.01 0.01 unit=V
* @spec capture2 range 3.2 3.4 unit=V
* @spec hold2 range 3.2 3.4 unit=V
* @spec capture3 range -0.01 0.01 unit=V
* @spec hold3 range -0.01 0.01 unit=V
* @spec capture4 range 3.2 3.4 unit=V
.control
set filetype=ascii
tran 10p 210n
meas tran capture1 FIND v(q) AT=30n
meas tran hold1 FIND v(q) AT=50n
meas tran capture0 FIND v(q) AT=68n
meas tran hold0 FIND v(q) AT=90n
meas tran capture2 FIND v(q) AT=108n
meas tran hold2 FIND v(q) AT=130n
meas tran capture3 FIND v(q) AT=148n
meas tran hold3 FIND v(q) AT=170n
meas tran capture4 FIND v(q) AT=190n
write out.raw
quit
.endc
.end
