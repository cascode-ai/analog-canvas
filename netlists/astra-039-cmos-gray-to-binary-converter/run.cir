CMOS 3-bit Gray-to-binary converter
.include "circuit.spice"
.include "models.spice"
VDD vdd 0 3.3
VG0 g0 0 PULSE(0 3.3 40n 100p 100p 39.9n 80n)
VG1 g1 0 PULSE(0 3.3 80n 100p 100p 79.9n 160n)
VG2 g2 0 PULSE(0 3.3 160n 100p 100p 159.9n 320n)
XDUT vdd 0 g2 g1 g0 b1 b0 b2 astra_039_cmos_gray_to_binary_converter
.temp 27
.options method=gear reltol=1e-5
* @spec c0b0 range -0.01 0.01 unit=V
* @spec c0b1 range -0.01 0.01 unit=V
* @spec c0b2 range -0.01 0.01 unit=V
* @spec c1b0 range 3.2 3.4 unit=V
* @spec c1b1 range -0.01 0.01 unit=V
* @spec c1b2 range -0.01 0.01 unit=V
* @spec c2b0 range 3.2 3.4 unit=V
* @spec c2b1 range 3.2 3.4 unit=V
* @spec c2b2 range -0.01 0.01 unit=V
* @spec c3b0 range -0.01 0.01 unit=V
* @spec c3b1 range 3.2 3.4 unit=V
* @spec c3b2 range -0.01 0.01 unit=V
* @spec c4b0 range 3.2 3.4 unit=V
* @spec c4b1 range 3.2 3.4 unit=V
* @spec c4b2 range 3.2 3.4 unit=V
* @spec c5b0 range -0.01 0.01 unit=V
* @spec c5b1 range 3.2 3.4 unit=V
* @spec c5b2 range 3.2 3.4 unit=V
* @spec c6b0 range -0.01 0.01 unit=V
* @spec c6b1 range -0.01 0.01 unit=V
* @spec c6b2 range 3.2 3.4 unit=V
* @spec c7b0 range 3.2 3.4 unit=V
* @spec c7b1 range -0.01 0.01 unit=V
* @spec c7b2 range 3.2 3.4 unit=V
.control
set filetype=ascii
tran 20p 320n
meas tran c0b0 FIND v(b0) AT=20n
meas tran c0b1 FIND v(b1) AT=20n
meas tran c0b2 FIND v(b2) AT=20n
meas tran c1b0 FIND v(b0) AT=60n
meas tran c1b1 FIND v(b1) AT=60n
meas tran c1b2 FIND v(b2) AT=60n
meas tran c2b0 FIND v(b0) AT=100n
meas tran c2b1 FIND v(b1) AT=100n
meas tran c2b2 FIND v(b2) AT=100n
meas tran c3b0 FIND v(b0) AT=140n
meas tran c3b1 FIND v(b1) AT=140n
meas tran c3b2 FIND v(b2) AT=140n
meas tran c4b0 FIND v(b0) AT=180n
meas tran c4b1 FIND v(b1) AT=180n
meas tran c4b2 FIND v(b2) AT=180n
meas tran c5b0 FIND v(b0) AT=220n
meas tran c5b1 FIND v(b1) AT=220n
meas tran c5b2 FIND v(b2) AT=220n
meas tran c6b0 FIND v(b0) AT=260n
meas tran c6b1 FIND v(b1) AT=260n
meas tran c6b2 FIND v(b2) AT=260n
meas tran c7b0 FIND v(b0) AT=300n
meas tran c7b1 FIND v(b1) AT=300n
meas tran c7b2 FIND v(b2) AT=300n
write out.raw
quit
.endc
.end
