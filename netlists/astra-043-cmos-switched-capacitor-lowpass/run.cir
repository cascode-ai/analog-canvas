CMOS switched-capacitor low-pass filter
.include "circuit.spice"
.include "models.spice"
VDD vdd 0 3.3
VL vin vh SIN(1.2 0.2 10k)
VH vh 0 SIN(0 0.2 100k)
VP1 p1 0 PULSE(0 3.3 20n 1n 1n 430n 1u)
VP2 p2 0 PULSE(0 3.3 520n 1n 1n 430n 1u)
XDUT vdd 0 vin out p1 p2 astra_043_cmos_switched_capacitor_lowpass
.temp 27
.options method=gear reltol=1e-5
* @spec low_sin range 0.05 0.09 unit=V
* @spec low_cos range -0.06 -0.02 unit=V
* @spec high_sin range -0.015 0.015 unit=V
* @spec high_cos range -0.025 -0.005 unit=V
* @spec mean range 1.19 1.21 unit=V
.control
set filetype=ascii
tran 10n 600u
let acout=v(out)-1.2
let li=acout*sin(2*pi*10k*time)
let lq=acout*cos(2*pi*10k*time)
let hi=acout*sin(2*pi*100k*time)
let hq=acout*cos(2*pi*100k*time)
meas tran low_sin AVG li FROM=200u TO=600u
meas tran low_cos AVG lq FROM=200u TO=600u
meas tran high_sin AVG hi FROM=200u TO=600u
meas tran high_cos AVG hq FROM=200u TO=600u
meas tran mean AVG v(out) FROM=200u TO=600u
write out.raw v(vin) v(out) v(p1) v(p2)
quit
.endc
.end
