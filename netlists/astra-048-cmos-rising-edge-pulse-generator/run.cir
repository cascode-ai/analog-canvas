CMOS rising-edge pulse generator
.include "circuit.spice"
.include "models.spice"
VDD vdd 0 3.3
VIN inp 0 PULSE(0 3.3 20n 100p 100p 19.9n 40n)
XDUT vdd 0 inp out astra_048_cmos_rising_edge_pulse_generator
.temp 27
.options method=gear reltol=1e-5
* @spec rise1 range 3.2 3.4 unit=V
* @spec fall1 range -0.01 0.1 unit=V
* @spec quiet range -0.01 0.1 unit=V
* @spec rise2 range 3.2 3.4 unit=V
* @spec width range 2e-9 8e-9 unit=s
* @spec period range 3.9e-8 4.1e-8 unit=s
.control
set filetype=ascii
tran 10p 120n
meas tran rise1 MAX v(out) FROM=20n TO=28n
meas tran fall1 MAX v(out) FROM=40n TO=49n
meas tran quiet MAX v(out) FROM=30n TO=55n
meas tran rise2 MAX v(out) FROM=60n TO=68n
meas tran width TRIG v(out) VAL=1.65 RISE=1 TARG v(out) VAL=1.65 FALL=1
meas tran period TRIG v(out) VAL=1.65 RISE=1 TARG v(out) VAL=1.65 RISE=2
write out.raw
quit
.endc
.end
