CMOS 2-bit Johnson counter
.include "circuit.spice"
.include "models.spice"
VDD vdd 0 3.3
VCLK clk 0 PULSE(0 3.3 20n 100p 100p 19.9n 40n)
.ic v(q0)=0 v(q1)=0
XDUT vdd 0 q0 q1 clk astra_049_cmos_two_bit_johnson_counter
.temp 27
.options method=gear reltol=1e-5
* @spec s0q0 range 3.2 3.4 unit=V
* @spec s0q1 range -0.01 0.01 unit=V
* @spec s1q0 range 3.2 3.4 unit=V
* @spec s1q1 range 3.2 3.4 unit=V
* @spec s2q0 range -0.01 0.01 unit=V
* @spec s2q1 range 3.2 3.4 unit=V
* @spec s3q0 range -0.01 0.01 unit=V
* @spec s3q1 range -0.01 0.01 unit=V
* @spec s4q0 range 3.2 3.4 unit=V
* @spec s4q1 range -0.01 0.01 unit=V
* @spec s5q0 range 3.2 3.4 unit=V
* @spec s5q1 range 3.2 3.4 unit=V
* @spec s6q0 range -0.01 0.01 unit=V
* @spec s6q1 range 3.2 3.4 unit=V
* @spec s7q0 range -0.01 0.01 unit=V
* @spec s7q1 range -0.01 0.01 unit=V
* @spec period range 1.59e-7 1.61e-7 unit=s
* @spec phase range 3.9e-8 4.1e-8 unit=s
* @spec width range 7.9e-8 8.1e-8 unit=s
.control
set filetype=ascii
tran 20p 500n
meas tran s0q0 FIND v(q0) AT=30n
meas tran s0q1 FIND v(q1) AT=30n
meas tran s1q0 FIND v(q0) AT=70n
meas tran s1q1 FIND v(q1) AT=70n
meas tran s2q0 FIND v(q0) AT=110n
meas tran s2q1 FIND v(q1) AT=110n
meas tran s3q0 FIND v(q0) AT=150n
meas tran s3q1 FIND v(q1) AT=150n
meas tran s4q0 FIND v(q0) AT=190n
meas tran s4q1 FIND v(q1) AT=190n
meas tran s5q0 FIND v(q0) AT=230n
meas tran s5q1 FIND v(q1) AT=230n
meas tran s6q0 FIND v(q0) AT=270n
meas tran s6q1 FIND v(q1) AT=270n
meas tran s7q0 FIND v(q0) AT=310n
meas tran s7q1 FIND v(q1) AT=310n
meas tran period TRIG v(q0) VAL=1.65 RISE=2 TARG v(q0) VAL=1.65 RISE=3
meas tran phase TRIG v(q0) VAL=1.65 RISE=1 TARG v(q1) VAL=1.65 RISE=1
meas tran width TRIG v(q0) VAL=1.65 RISE=1 TARG v(q0) VAL=1.65 FALL=1
write out.raw
quit
.endc
.end
