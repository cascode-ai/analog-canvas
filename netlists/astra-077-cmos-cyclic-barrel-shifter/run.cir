CMOS 4-bit cyclic barrel shifter
.include "circuit.spice"
.include "models.spice"
VDD vdd 0 3.3
VD0 d0 0 PULSE(0 3.3 50n 100p 100p 49.9n 100n)
VD1 d1 0 PULSE(0 3.3 100n 100p 100p 99.9n 200n)
VD2 d2 0 PULSE(0 3.3 200n 100p 100p 199.9n 400n)
VD3 d3 0 PULSE(0 3.3 400n 100p 100p 399.9n 800n)
VS0 s0 0 PULSE(0 3.3 800n 100p 100p 799.9n 1600n)
VS1 s1 0 PULSE(0 3.3 1600n 100p 100p 1599.9n 3200n)
XDUT vdd 0 d0 y0 d1 y1 d2 y2 d3 y3 s0 s1 astra_077_cmos_cyclic_barrel_shifter
.temp 27
.options method=gear reltol=1e-5
* @spec w0b0 range -0.02 0.02 unit=V
* @spec w0b1 range -0.02 0.02 unit=V
* @spec w0b2 range -0.02 0.02 unit=V
* @spec w0b3 range -0.02 0.02 unit=V
* @spec w1b0 range 3.2 3.4 unit=V
* @spec w1b1 range -0.02 0.02 unit=V
* @spec w1b2 range -0.02 0.02 unit=V
* @spec w1b3 range -0.02 0.02 unit=V
* @spec w2b0 range -0.02 0.02 unit=V
* @spec w2b1 range 3.2 3.4 unit=V
* @spec w2b2 range -0.02 0.02 unit=V
* @spec w2b3 range -0.02 0.02 unit=V
* @spec w3b0 range 3.2 3.4 unit=V
* @spec w3b1 range 3.2 3.4 unit=V
* @spec w3b2 range -0.02 0.02 unit=V
* @spec w3b3 range -0.02 0.02 unit=V
* @spec w4b0 range -0.02 0.02 unit=V
* @spec w4b1 range -0.02 0.02 unit=V
* @spec w4b2 range 3.2 3.4 unit=V
* @spec w4b3 range -0.02 0.02 unit=V
* @spec w5b0 range 3.2 3.4 unit=V
* @spec w5b1 range -0.02 0.02 unit=V
* @spec w5b2 range 3.2 3.4 unit=V
* @spec w5b3 range -0.02 0.02 unit=V
* @spec w6b0 range -0.02 0.02 unit=V
* @spec w6b1 range 3.2 3.4 unit=V
* @spec w6b2 range 3.2 3.4 unit=V
* @spec w6b3 range -0.02 0.02 unit=V
* @spec w7b0 range 3.2 3.4 unit=V
* @spec w7b1 range 3.2 3.4 unit=V
* @spec w7b2 range 3.2 3.4 unit=V
* @spec w7b3 range -0.02 0.02 unit=V
* @spec w8b0 range -0.02 0.02 unit=V
* @spec w8b1 range -0.02 0.02 unit=V
* @spec w8b2 range -0.02 0.02 unit=V
* @spec w8b3 range 3.2 3.4 unit=V
* @spec w9b0 range 3.2 3.4 unit=V
* @spec w9b1 range -0.02 0.02 unit=V
* @spec w9b2 range -0.02 0.02 unit=V
* @spec w9b3 range 3.2 3.4 unit=V
* @spec w10b0 range -0.02 0.02 unit=V
* @spec w10b1 range 3.2 3.4 unit=V
* @spec w10b2 range -0.02 0.02 unit=V
* @spec w10b3 range 3.2 3.4 unit=V
* @spec w11b0 range 3.2 3.4 unit=V
* @spec w11b1 range 3.2 3.4 unit=V
* @spec w11b2 range -0.02 0.02 unit=V
* @spec w11b3 range 3.2 3.4 unit=V
* @spec w12b0 range -0.02 0.02 unit=V
* @spec w12b1 range -0.02 0.02 unit=V
* @spec w12b2 range 3.2 3.4 unit=V
* @spec w12b3 range 3.2 3.4 unit=V
* @spec w13b0 range 3.2 3.4 unit=V
* @spec w13b1 range -0.02 0.02 unit=V
* @spec w13b2 range 3.2 3.4 unit=V
* @spec w13b3 range 3.2 3.4 unit=V
* @spec w14b0 range -0.02 0.02 unit=V
* @spec w14b1 range 3.2 3.4 unit=V
* @spec w14b2 range 3.2 3.4 unit=V
* @spec w14b3 range 3.2 3.4 unit=V
* @spec w15b0 range 3.2 3.4 unit=V
* @spec w15b1 range 3.2 3.4 unit=V
* @spec w15b2 range 3.2 3.4 unit=V
* @spec w15b3 range 3.2 3.4 unit=V
* @spec w16b0 range -0.02 0.02 unit=V
* @spec w16b1 range -0.02 0.02 unit=V
* @spec w16b2 range -0.02 0.02 unit=V
* @spec w16b3 range -0.02 0.02 unit=V
* @spec w17b0 range -0.02 0.02 unit=V
* @spec w17b1 range 3.2 3.4 unit=V
* @spec w17b2 range -0.02 0.02 unit=V
* @spec w17b3 range -0.02 0.02 unit=V
* @spec w18b0 range -0.02 0.02 unit=V
* @spec w18b1 range -0.02 0.02 unit=V
* @spec w18b2 range 3.2 3.4 unit=V
* @spec w18b3 range -0.02 0.02 unit=V
* @spec w19b0 range -0.02 0.02 unit=V
* @spec w19b1 range 3.2 3.4 unit=V
* @spec w19b2 range 3.2 3.4 unit=V
* @spec w19b3 range -0.02 0.02 unit=V
* @spec w20b0 range -0.02 0.02 unit=V
* @spec w20b1 range -0.02 0.02 unit=V
* @spec w20b2 range -0.02 0.02 unit=V
* @spec w20b3 range 3.2 3.4 unit=V
* @spec w21b0 range -0.02 0.02 unit=V
* @spec w21b1 range 3.2 3.4 unit=V
* @spec w21b2 range -0.02 0.02 unit=V
* @spec w21b3 range 3.2 3.4 unit=V
* @spec w22b0 range -0.02 0.02 unit=V
* @spec w22b1 range -0.02 0.02 unit=V
* @spec w22b2 range 3.2 3.4 unit=V
* @spec w22b3 range 3.2 3.4 unit=V
* @spec w23b0 range -0.02 0.02 unit=V
* @spec w23b1 range 3.2 3.4 unit=V
* @spec w23b2 range 3.2 3.4 unit=V
* @spec w23b3 range 3.2 3.4 unit=V
* @spec w24b0 range 3.2 3.4 unit=V
* @spec w24b1 range -0.02 0.02 unit=V
* @spec w24b2 range -0.02 0.02 unit=V
* @spec w24b3 range -0.02 0.02 unit=V
* @spec w25b0 range 3.2 3.4 unit=V
* @spec w25b1 range 3.2 3.4 unit=V
* @spec w25b2 range -0.02 0.02 unit=V
* @spec w25b3 range -0.02 0.02 unit=V
* @spec w26b0 range 3.2 3.4 unit=V
* @spec w26b1 range -0.02 0.02 unit=V
* @spec w26b2 range 3.2 3.4 unit=V
* @spec w26b3 range -0.02 0.02 unit=V
* @spec w27b0 range 3.2 3.4 unit=V
* @spec w27b1 range 3.2 3.4 unit=V
* @spec w27b2 range 3.2 3.4 unit=V
* @spec w27b3 range -0.02 0.02 unit=V
* @spec w28b0 range 3.2 3.4 unit=V
* @spec w28b1 range -0.02 0.02 unit=V
* @spec w28b2 range -0.02 0.02 unit=V
* @spec w28b3 range 3.2 3.4 unit=V
* @spec w29b0 range 3.2 3.4 unit=V
* @spec w29b1 range 3.2 3.4 unit=V
* @spec w29b2 range -0.02 0.02 unit=V
* @spec w29b3 range 3.2 3.4 unit=V
* @spec w30b0 range 3.2 3.4 unit=V
* @spec w30b1 range -0.02 0.02 unit=V
* @spec w30b2 range 3.2 3.4 unit=V
* @spec w30b3 range 3.2 3.4 unit=V
* @spec w31b0 range 3.2 3.4 unit=V
* @spec w31b1 range 3.2 3.4 unit=V
* @spec w31b2 range 3.2 3.4 unit=V
* @spec w31b3 range 3.2 3.4 unit=V
* @spec w32b0 range -0.02 0.02 unit=V
* @spec w32b1 range -0.02 0.02 unit=V
* @spec w32b2 range -0.02 0.02 unit=V
* @spec w32b3 range -0.02 0.02 unit=V
* @spec w33b0 range -0.02 0.02 unit=V
* @spec w33b1 range -0.02 0.02 unit=V
* @spec w33b2 range 3.2 3.4 unit=V
* @spec w33b3 range -0.02 0.02 unit=V
* @spec w34b0 range -0.02 0.02 unit=V
* @spec w34b1 range -0.02 0.02 unit=V
* @spec w34b2 range -0.02 0.02 unit=V
* @spec w34b3 range 3.2 3.4 unit=V
* @spec w35b0 range -0.02 0.02 unit=V
* @spec w35b1 range -0.02 0.02 unit=V
* @spec w35b2 range 3.2 3.4 unit=V
* @spec w35b3 range 3.2 3.4 unit=V
* @spec w36b0 range 3.2 3.4 unit=V
* @spec w36b1 range -0.02 0.02 unit=V
* @spec w36b2 range -0.02 0.02 unit=V
* @spec w36b3 range -0.02 0.02 unit=V
* @spec w37b0 range 3.2 3.4 unit=V
* @spec w37b1 range -0.02 0.02 unit=V
* @spec w37b2 range 3.2 3.4 unit=V
* @spec w37b3 range -0.02 0.02 unit=V
* @spec w38b0 range 3.2 3.4 unit=V
* @spec w38b1 range -0.02 0.02 unit=V
* @spec w38b2 range -0.02 0.02 unit=V
* @spec w38b3 range 3.2 3.4 unit=V
* @spec w39b0 range 3.2 3.4 unit=V
* @spec w39b1 range -0.02 0.02 unit=V
* @spec w39b2 range 3.2 3.4 unit=V
* @spec w39b3 range 3.2 3.4 unit=V
* @spec w40b0 range -0.02 0.02 unit=V
* @spec w40b1 range 3.2 3.4 unit=V
* @spec w40b2 range -0.02 0.02 unit=V
* @spec w40b3 range -0.02 0.02 unit=V
* @spec w41b0 range -0.02 0.02 unit=V
* @spec w41b1 range 3.2 3.4 unit=V
* @spec w41b2 range 3.2 3.4 unit=V
* @spec w41b3 range -0.02 0.02 unit=V
* @spec w42b0 range -0.02 0.02 unit=V
* @spec w42b1 range 3.2 3.4 unit=V
* @spec w42b2 range -0.02 0.02 unit=V
* @spec w42b3 range 3.2 3.4 unit=V
* @spec w43b0 range -0.02 0.02 unit=V
* @spec w43b1 range 3.2 3.4 unit=V
* @spec w43b2 range 3.2 3.4 unit=V
* @spec w43b3 range 3.2 3.4 unit=V
* @spec w44b0 range 3.2 3.4 unit=V
* @spec w44b1 range 3.2 3.4 unit=V
* @spec w44b2 range -0.02 0.02 unit=V
* @spec w44b3 range -0.02 0.02 unit=V
* @spec w45b0 range 3.2 3.4 unit=V
* @spec w45b1 range 3.2 3.4 unit=V
* @spec w45b2 range 3.2 3.4 unit=V
* @spec w45b3 range -0.02 0.02 unit=V
* @spec w46b0 range 3.2 3.4 unit=V
* @spec w46b1 range 3.2 3.4 unit=V
* @spec w46b2 range -0.02 0.02 unit=V
* @spec w46b3 range 3.2 3.4 unit=V
* @spec w47b0 range 3.2 3.4 unit=V
* @spec w47b1 range 3.2 3.4 unit=V
* @spec w47b2 range 3.2 3.4 unit=V
* @spec w47b3 range 3.2 3.4 unit=V
* @spec w48b0 range -0.02 0.02 unit=V
* @spec w48b1 range -0.02 0.02 unit=V
* @spec w48b2 range -0.02 0.02 unit=V
* @spec w48b3 range -0.02 0.02 unit=V
* @spec w49b0 range -0.02 0.02 unit=V
* @spec w49b1 range -0.02 0.02 unit=V
* @spec w49b2 range -0.02 0.02 unit=V
* @spec w49b3 range 3.2 3.4 unit=V
* @spec w50b0 range 3.2 3.4 unit=V
* @spec w50b1 range -0.02 0.02 unit=V
* @spec w50b2 range -0.02 0.02 unit=V
* @spec w50b3 range -0.02 0.02 unit=V
* @spec w51b0 range 3.2 3.4 unit=V
* @spec w51b1 range -0.02 0.02 unit=V
* @spec w51b2 range -0.02 0.02 unit=V
* @spec w51b3 range 3.2 3.4 unit=V
* @spec w52b0 range -0.02 0.02 unit=V
* @spec w52b1 range 3.2 3.4 unit=V
* @spec w52b2 range -0.02 0.02 unit=V
* @spec w52b3 range -0.02 0.02 unit=V
* @spec w53b0 range -0.02 0.02 unit=V
* @spec w53b1 range 3.2 3.4 unit=V
* @spec w53b2 range -0.02 0.02 unit=V
* @spec w53b3 range 3.2 3.4 unit=V
* @spec w54b0 range 3.2 3.4 unit=V
* @spec w54b1 range 3.2 3.4 unit=V
* @spec w54b2 range -0.02 0.02 unit=V
* @spec w54b3 range -0.02 0.02 unit=V
* @spec w55b0 range 3.2 3.4 unit=V
* @spec w55b1 range 3.2 3.4 unit=V
* @spec w55b2 range -0.02 0.02 unit=V
* @spec w55b3 range 3.2 3.4 unit=V
* @spec w56b0 range -0.02 0.02 unit=V
* @spec w56b1 range -0.02 0.02 unit=V
* @spec w56b2 range 3.2 3.4 unit=V
* @spec w56b3 range -0.02 0.02 unit=V
* @spec w57b0 range -0.02 0.02 unit=V
* @spec w57b1 range -0.02 0.02 unit=V
* @spec w57b2 range 3.2 3.4 unit=V
* @spec w57b3 range 3.2 3.4 unit=V
* @spec w58b0 range 3.2 3.4 unit=V
* @spec w58b1 range -0.02 0.02 unit=V
* @spec w58b2 range 3.2 3.4 unit=V
* @spec w58b3 range -0.02 0.02 unit=V
* @spec w59b0 range 3.2 3.4 unit=V
* @spec w59b1 range -0.02 0.02 unit=V
* @spec w59b2 range 3.2 3.4 unit=V
* @spec w59b3 range 3.2 3.4 unit=V
* @spec w60b0 range -0.02 0.02 unit=V
* @spec w60b1 range 3.2 3.4 unit=V
* @spec w60b2 range 3.2 3.4 unit=V
* @spec w60b3 range -0.02 0.02 unit=V
* @spec w61b0 range -0.02 0.02 unit=V
* @spec w61b1 range 3.2 3.4 unit=V
* @spec w61b2 range 3.2 3.4 unit=V
* @spec w61b3 range 3.2 3.4 unit=V
* @spec w62b0 range 3.2 3.4 unit=V
* @spec w62b1 range 3.2 3.4 unit=V
* @spec w62b2 range 3.2 3.4 unit=V
* @spec w62b3 range -0.02 0.02 unit=V
* @spec w63b0 range 3.2 3.4 unit=V
* @spec w63b1 range 3.2 3.4 unit=V
* @spec w63b2 range 3.2 3.4 unit=V
* @spec w63b3 range 3.2 3.4 unit=V
.control
set filetype=ascii
tran 100p 3.2u
meas tran w0b0 FIND v(y0) AT=30n
meas tran w0b1 FIND v(y1) AT=30n
meas tran w0b2 FIND v(y2) AT=30n
meas tran w0b3 FIND v(y3) AT=30n
meas tran w1b0 FIND v(y0) AT=80n
meas tran w1b1 FIND v(y1) AT=80n
meas tran w1b2 FIND v(y2) AT=80n
meas tran w1b3 FIND v(y3) AT=80n
meas tran w2b0 FIND v(y0) AT=130n
meas tran w2b1 FIND v(y1) AT=130n
meas tran w2b2 FIND v(y2) AT=130n
meas tran w2b3 FIND v(y3) AT=130n
meas tran w3b0 FIND v(y0) AT=180n
meas tran w3b1 FIND v(y1) AT=180n
meas tran w3b2 FIND v(y2) AT=180n
meas tran w3b3 FIND v(y3) AT=180n
meas tran w4b0 FIND v(y0) AT=230n
meas tran w4b1 FIND v(y1) AT=230n
meas tran w4b2 FIND v(y2) AT=230n
meas tran w4b3 FIND v(y3) AT=230n
meas tran w5b0 FIND v(y0) AT=280n
meas tran w5b1 FIND v(y1) AT=280n
meas tran w5b2 FIND v(y2) AT=280n
meas tran w5b3 FIND v(y3) AT=280n
meas tran w6b0 FIND v(y0) AT=330n
meas tran w6b1 FIND v(y1) AT=330n
meas tran w6b2 FIND v(y2) AT=330n
meas tran w6b3 FIND v(y3) AT=330n
meas tran w7b0 FIND v(y0) AT=380n
meas tran w7b1 FIND v(y1) AT=380n
meas tran w7b2 FIND v(y2) AT=380n
meas tran w7b3 FIND v(y3) AT=380n
meas tran w8b0 FIND v(y0) AT=430n
meas tran w8b1 FIND v(y1) AT=430n
meas tran w8b2 FIND v(y2) AT=430n
meas tran w8b3 FIND v(y3) AT=430n
meas tran w9b0 FIND v(y0) AT=480n
meas tran w9b1 FIND v(y1) AT=480n
meas tran w9b2 FIND v(y2) AT=480n
meas tran w9b3 FIND v(y3) AT=480n
meas tran w10b0 FIND v(y0) AT=530n
meas tran w10b1 FIND v(y1) AT=530n
meas tran w10b2 FIND v(y2) AT=530n
meas tran w10b3 FIND v(y3) AT=530n
meas tran w11b0 FIND v(y0) AT=580n
meas tran w11b1 FIND v(y1) AT=580n
meas tran w11b2 FIND v(y2) AT=580n
meas tran w11b3 FIND v(y3) AT=580n
meas tran w12b0 FIND v(y0) AT=630n
meas tran w12b1 FIND v(y1) AT=630n
meas tran w12b2 FIND v(y2) AT=630n
meas tran w12b3 FIND v(y3) AT=630n
meas tran w13b0 FIND v(y0) AT=680n
meas tran w13b1 FIND v(y1) AT=680n
meas tran w13b2 FIND v(y2) AT=680n
meas tran w13b3 FIND v(y3) AT=680n
meas tran w14b0 FIND v(y0) AT=730n
meas tran w14b1 FIND v(y1) AT=730n
meas tran w14b2 FIND v(y2) AT=730n
meas tran w14b3 FIND v(y3) AT=730n
meas tran w15b0 FIND v(y0) AT=780n
meas tran w15b1 FIND v(y1) AT=780n
meas tran w15b2 FIND v(y2) AT=780n
meas tran w15b3 FIND v(y3) AT=780n
meas tran w16b0 FIND v(y0) AT=830n
meas tran w16b1 FIND v(y1) AT=830n
meas tran w16b2 FIND v(y2) AT=830n
meas tran w16b3 FIND v(y3) AT=830n
meas tran w17b0 FIND v(y0) AT=880n
meas tran w17b1 FIND v(y1) AT=880n
meas tran w17b2 FIND v(y2) AT=880n
meas tran w17b3 FIND v(y3) AT=880n
meas tran w18b0 FIND v(y0) AT=930n
meas tran w18b1 FIND v(y1) AT=930n
meas tran w18b2 FIND v(y2) AT=930n
meas tran w18b3 FIND v(y3) AT=930n
meas tran w19b0 FIND v(y0) AT=980n
meas tran w19b1 FIND v(y1) AT=980n
meas tran w19b2 FIND v(y2) AT=980n
meas tran w19b3 FIND v(y3) AT=980n
meas tran w20b0 FIND v(y0) AT=1030n
meas tran w20b1 FIND v(y1) AT=1030n
meas tran w20b2 FIND v(y2) AT=1030n
meas tran w20b3 FIND v(y3) AT=1030n
meas tran w21b0 FIND v(y0) AT=1080n
meas tran w21b1 FIND v(y1) AT=1080n
meas tran w21b2 FIND v(y2) AT=1080n
meas tran w21b3 FIND v(y3) AT=1080n
meas tran w22b0 FIND v(y0) AT=1130n
meas tran w22b1 FIND v(y1) AT=1130n
meas tran w22b2 FIND v(y2) AT=1130n
meas tran w22b3 FIND v(y3) AT=1130n
meas tran w23b0 FIND v(y0) AT=1180n
meas tran w23b1 FIND v(y1) AT=1180n
meas tran w23b2 FIND v(y2) AT=1180n
meas tran w23b3 FIND v(y3) AT=1180n
meas tran w24b0 FIND v(y0) AT=1230n
meas tran w24b1 FIND v(y1) AT=1230n
meas tran w24b2 FIND v(y2) AT=1230n
meas tran w24b3 FIND v(y3) AT=1230n
meas tran w25b0 FIND v(y0) AT=1280n
meas tran w25b1 FIND v(y1) AT=1280n
meas tran w25b2 FIND v(y2) AT=1280n
meas tran w25b3 FIND v(y3) AT=1280n
meas tran w26b0 FIND v(y0) AT=1330n
meas tran w26b1 FIND v(y1) AT=1330n
meas tran w26b2 FIND v(y2) AT=1330n
meas tran w26b3 FIND v(y3) AT=1330n
meas tran w27b0 FIND v(y0) AT=1380n
meas tran w27b1 FIND v(y1) AT=1380n
meas tran w27b2 FIND v(y2) AT=1380n
meas tran w27b3 FIND v(y3) AT=1380n
meas tran w28b0 FIND v(y0) AT=1430n
meas tran w28b1 FIND v(y1) AT=1430n
meas tran w28b2 FIND v(y2) AT=1430n
meas tran w28b3 FIND v(y3) AT=1430n
meas tran w29b0 FIND v(y0) AT=1480n
meas tran w29b1 FIND v(y1) AT=1480n
meas tran w29b2 FIND v(y2) AT=1480n
meas tran w29b3 FIND v(y3) AT=1480n
meas tran w30b0 FIND v(y0) AT=1530n
meas tran w30b1 FIND v(y1) AT=1530n
meas tran w30b2 FIND v(y2) AT=1530n
meas tran w30b3 FIND v(y3) AT=1530n
meas tran w31b0 FIND v(y0) AT=1580n
meas tran w31b1 FIND v(y1) AT=1580n
meas tran w31b2 FIND v(y2) AT=1580n
meas tran w31b3 FIND v(y3) AT=1580n
meas tran w32b0 FIND v(y0) AT=1630n
meas tran w32b1 FIND v(y1) AT=1630n
meas tran w32b2 FIND v(y2) AT=1630n
meas tran w32b3 FIND v(y3) AT=1630n
meas tran w33b0 FIND v(y0) AT=1680n
meas tran w33b1 FIND v(y1) AT=1680n
meas tran w33b2 FIND v(y2) AT=1680n
meas tran w33b3 FIND v(y3) AT=1680n
meas tran w34b0 FIND v(y0) AT=1730n
meas tran w34b1 FIND v(y1) AT=1730n
meas tran w34b2 FIND v(y2) AT=1730n
meas tran w34b3 FIND v(y3) AT=1730n
meas tran w35b0 FIND v(y0) AT=1780n
meas tran w35b1 FIND v(y1) AT=1780n
meas tran w35b2 FIND v(y2) AT=1780n
meas tran w35b3 FIND v(y3) AT=1780n
meas tran w36b0 FIND v(y0) AT=1830n
meas tran w36b1 FIND v(y1) AT=1830n
meas tran w36b2 FIND v(y2) AT=1830n
meas tran w36b3 FIND v(y3) AT=1830n
meas tran w37b0 FIND v(y0) AT=1880n
meas tran w37b1 FIND v(y1) AT=1880n
meas tran w37b2 FIND v(y2) AT=1880n
meas tran w37b3 FIND v(y3) AT=1880n
meas tran w38b0 FIND v(y0) AT=1930n
meas tran w38b1 FIND v(y1) AT=1930n
meas tran w38b2 FIND v(y2) AT=1930n
meas tran w38b3 FIND v(y3) AT=1930n
meas tran w39b0 FIND v(y0) AT=1980n
meas tran w39b1 FIND v(y1) AT=1980n
meas tran w39b2 FIND v(y2) AT=1980n
meas tran w39b3 FIND v(y3) AT=1980n
meas tran w40b0 FIND v(y0) AT=2030n
meas tran w40b1 FIND v(y1) AT=2030n
meas tran w40b2 FIND v(y2) AT=2030n
meas tran w40b3 FIND v(y3) AT=2030n
meas tran w41b0 FIND v(y0) AT=2080n
meas tran w41b1 FIND v(y1) AT=2080n
meas tran w41b2 FIND v(y2) AT=2080n
meas tran w41b3 FIND v(y3) AT=2080n
meas tran w42b0 FIND v(y0) AT=2130n
meas tran w42b1 FIND v(y1) AT=2130n
meas tran w42b2 FIND v(y2) AT=2130n
meas tran w42b3 FIND v(y3) AT=2130n
meas tran w43b0 FIND v(y0) AT=2180n
meas tran w43b1 FIND v(y1) AT=2180n
meas tran w43b2 FIND v(y2) AT=2180n
meas tran w43b3 FIND v(y3) AT=2180n
meas tran w44b0 FIND v(y0) AT=2230n
meas tran w44b1 FIND v(y1) AT=2230n
meas tran w44b2 FIND v(y2) AT=2230n
meas tran w44b3 FIND v(y3) AT=2230n
meas tran w45b0 FIND v(y0) AT=2280n
meas tran w45b1 FIND v(y1) AT=2280n
meas tran w45b2 FIND v(y2) AT=2280n
meas tran w45b3 FIND v(y3) AT=2280n
meas tran w46b0 FIND v(y0) AT=2330n
meas tran w46b1 FIND v(y1) AT=2330n
meas tran w46b2 FIND v(y2) AT=2330n
meas tran w46b3 FIND v(y3) AT=2330n
meas tran w47b0 FIND v(y0) AT=2380n
meas tran w47b1 FIND v(y1) AT=2380n
meas tran w47b2 FIND v(y2) AT=2380n
meas tran w47b3 FIND v(y3) AT=2380n
meas tran w48b0 FIND v(y0) AT=2430n
meas tran w48b1 FIND v(y1) AT=2430n
meas tran w48b2 FIND v(y2) AT=2430n
meas tran w48b3 FIND v(y3) AT=2430n
meas tran w49b0 FIND v(y0) AT=2480n
meas tran w49b1 FIND v(y1) AT=2480n
meas tran w49b2 FIND v(y2) AT=2480n
meas tran w49b3 FIND v(y3) AT=2480n
meas tran w50b0 FIND v(y0) AT=2530n
meas tran w50b1 FIND v(y1) AT=2530n
meas tran w50b2 FIND v(y2) AT=2530n
meas tran w50b3 FIND v(y3) AT=2530n
meas tran w51b0 FIND v(y0) AT=2580n
meas tran w51b1 FIND v(y1) AT=2580n
meas tran w51b2 FIND v(y2) AT=2580n
meas tran w51b3 FIND v(y3) AT=2580n
meas tran w52b0 FIND v(y0) AT=2630n
meas tran w52b1 FIND v(y1) AT=2630n
meas tran w52b2 FIND v(y2) AT=2630n
meas tran w52b3 FIND v(y3) AT=2630n
meas tran w53b0 FIND v(y0) AT=2680n
meas tran w53b1 FIND v(y1) AT=2680n
meas tran w53b2 FIND v(y2) AT=2680n
meas tran w53b3 FIND v(y3) AT=2680n
meas tran w54b0 FIND v(y0) AT=2730n
meas tran w54b1 FIND v(y1) AT=2730n
meas tran w54b2 FIND v(y2) AT=2730n
meas tran w54b3 FIND v(y3) AT=2730n
meas tran w55b0 FIND v(y0) AT=2780n
meas tran w55b1 FIND v(y1) AT=2780n
meas tran w55b2 FIND v(y2) AT=2780n
meas tran w55b3 FIND v(y3) AT=2780n
meas tran w56b0 FIND v(y0) AT=2830n
meas tran w56b1 FIND v(y1) AT=2830n
meas tran w56b2 FIND v(y2) AT=2830n
meas tran w56b3 FIND v(y3) AT=2830n
meas tran w57b0 FIND v(y0) AT=2880n
meas tran w57b1 FIND v(y1) AT=2880n
meas tran w57b2 FIND v(y2) AT=2880n
meas tran w57b3 FIND v(y3) AT=2880n
meas tran w58b0 FIND v(y0) AT=2930n
meas tran w58b1 FIND v(y1) AT=2930n
meas tran w58b2 FIND v(y2) AT=2930n
meas tran w58b3 FIND v(y3) AT=2930n
meas tran w59b0 FIND v(y0) AT=2980n
meas tran w59b1 FIND v(y1) AT=2980n
meas tran w59b2 FIND v(y2) AT=2980n
meas tran w59b3 FIND v(y3) AT=2980n
meas tran w60b0 FIND v(y0) AT=3030n
meas tran w60b1 FIND v(y1) AT=3030n
meas tran w60b2 FIND v(y2) AT=3030n
meas tran w60b3 FIND v(y3) AT=3030n
meas tran w61b0 FIND v(y0) AT=3080n
meas tran w61b1 FIND v(y1) AT=3080n
meas tran w61b2 FIND v(y2) AT=3080n
meas tran w61b3 FIND v(y3) AT=3080n
meas tran w62b0 FIND v(y0) AT=3130n
meas tran w62b1 FIND v(y1) AT=3130n
meas tran w62b2 FIND v(y2) AT=3130n
meas tran w62b3 FIND v(y3) AT=3130n
meas tran w63b0 FIND v(y0) AT=3180n
meas tran w63b1 FIND v(y1) AT=3180n
meas tran w63b2 FIND v(y2) AT=3180n
meas tran w63b3 FIND v(y3) AT=3180n
write out.raw v(y0) v(y1) v(y2) v(y3) v(s0) v(s1)
quit
.endc
.end
