CMOS filtered two-request arbiter
.include "circuit.spice"
.include "models.spice"
VDD vdd 0 3.3
VRA ra 0 PWL(0 0.0 99.5n 0.0 100.5n 3.3 199.5n 3.3 200.5n 3.3 299.5n 3.3 300.5n 0.0 399.5n 0.0 400.5n 0.0 499.5n 0.0 500.5n 0.0 599.5n 0.0 600.5n 3.3 699.5n 3.3 700.5n 3.3 799.5n 3.3 800.5n 0.0 899.5n 0.0 900.5n 3.3 1000n 3.3)
VRB rb 0 PWL(0 0.0 99.5n 0.0 100.5n 0.0 199.5n 0.0 200.5n 3.3 299.5n 3.3 300.5n 3.3 399.5n 3.3 400.5n 0.0 499.5n 0.0 500.5n 3.3 599.5n 3.3 600.5n 3.3 699.5n 3.3 700.5n 0.0 799.5n 0.0 800.5n 0.0 899.5n 0.0 900.5n 3.3 1000n 3.3)
XDUT vdd 0 ra rb ga gb astra_078_cmos_filtered_request_arbiter
.temp 27
.options method=gear reltol=1e-5
* @spec grant0ga range -0.02 0.02 unit=V
* @spec grant0gb range -0.02 0.02 unit=V
* @spec grant1ga range 3.2 3.4 unit=V
* @spec grant1gb range -0.02 0.02 unit=V
* @spec grant2ga range 3.2 3.4 unit=V
* @spec grant2gb range -0.02 0.02 unit=V
* @spec grant3ga range -0.02 0.02 unit=V
* @spec grant3gb range 3.2 3.4 unit=V
* @spec grant4ga range -0.02 0.02 unit=V
* @spec grant4gb range -0.02 0.02 unit=V
* @spec grant5ga range -0.02 0.02 unit=V
* @spec grant5gb range 3.2 3.4 unit=V
* @spec grant6ga range -0.02 0.02 unit=V
* @spec grant6gb range 3.2 3.4 unit=V
* @spec grant7ga range 3.2 3.4 unit=V
* @spec grant7gb range -0.02 0.02 unit=V
* @spec grant8ga range -0.02 0.02 unit=V
* @spec grant8gb range -0.02 0.02 unit=V
* @spec exclusive range -0.01 0.02 unit=dimensionless
.control
set filetype=ascii
tran 100p 1u
meas tran grant0ga FIND v(ga) AT=70n
meas tran grant0gb FIND v(gb) AT=70n
meas tran grant1ga FIND v(ga) AT=170n
meas tran grant1gb FIND v(gb) AT=170n
meas tran grant2ga FIND v(ga) AT=270n
meas tran grant2gb FIND v(gb) AT=270n
meas tran grant3ga FIND v(ga) AT=370n
meas tran grant3gb FIND v(gb) AT=370n
meas tran grant4ga FIND v(ga) AT=470n
meas tran grant4gb FIND v(gb) AT=470n
meas tran grant5ga FIND v(ga) AT=570n
meas tran grant5gb FIND v(gb) AT=570n
meas tran grant6ga FIND v(ga) AT=670n
meas tran grant6gb FIND v(gb) AT=670n
meas tran grant7ga FIND v(ga) AT=770n
meas tran grant7gb FIND v(gb) AT=770n
meas tran grant8ga FIND v(ga) AT=870n
meas tran grant8gb FIND v(gb) AT=870n
let overlap=v(ga)*v(gb)/(3.3*3.3)
meas tran exclusive MAX overlap FROM=920n TO=990n
write out.raw v(ga) v(gb) v(ra) v(rb)
quit
.endc
.end
