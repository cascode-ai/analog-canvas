CMOS three-bit Fibonacci LFSR
.include "circuit.spice"
.include "models.spice"
VDD vdd 0 3.3
VCLK clk 0 PULSE(0 3.3 20n 100p 100p 19.9n 40n)
.ic v(q0)=3.3 v(q1)=0 v(q2)=0 v(xdut.q0b)=0 v(xdut.q1b)=3.3 v(xdut.q2b)=3.3
XDUT vdd 0 q0 q1 q2 clk fb astra_084_cmos_three_bit_lfsr
.temp 27
.options method=gear reltol=1e-5
* @spec s0b0 range 3.2 3.4 unit=V
* @spec s0b1 range -0.02 0.02 unit=V
* @spec s0b2 range -0.02 0.02 unit=V
* @spec s1b0 range 3.2 3.4 unit=V
* @spec s1b1 range 3.2 3.4 unit=V
* @spec s1b2 range -0.02 0.02 unit=V
* @spec s2b0 range 3.2 3.4 unit=V
* @spec s2b1 range 3.2 3.4 unit=V
* @spec s2b2 range 3.2 3.4 unit=V
* @spec s3b0 range -0.02 0.02 unit=V
* @spec s3b1 range 3.2 3.4 unit=V
* @spec s3b2 range 3.2 3.4 unit=V
* @spec s4b0 range 3.2 3.4 unit=V
* @spec s4b1 range -0.02 0.02 unit=V
* @spec s4b2 range 3.2 3.4 unit=V
* @spec s5b0 range -0.02 0.02 unit=V
* @spec s5b1 range 3.2 3.4 unit=V
* @spec s5b2 range -0.02 0.02 unit=V
* @spec s6b0 range -0.02 0.02 unit=V
* @spec s6b1 range -0.02 0.02 unit=V
* @spec s6b2 range 3.2 3.4 unit=V
* @spec s7b0 range 3.2 3.4 unit=V
* @spec s7b1 range -0.02 0.02 unit=V
* @spec s7b2 range -0.02 0.02 unit=V
* @spec s8b0 range 3.2 3.4 unit=V
* @spec s8b1 range 3.2 3.4 unit=V
* @spec s8b2 range -0.02 0.02 unit=V
* @spec s9b0 range 3.2 3.4 unit=V
* @spec s9b1 range 3.2 3.4 unit=V
* @spec s9b2 range 3.2 3.4 unit=V
* @spec s10b0 range -0.02 0.02 unit=V
* @spec s10b1 range 3.2 3.4 unit=V
* @spec s10b2 range 3.2 3.4 unit=V
* @spec s11b0 range 3.2 3.4 unit=V
* @spec s11b1 range -0.02 0.02 unit=V
* @spec s11b2 range 3.2 3.4 unit=V
* @spec s12b0 range -0.02 0.02 unit=V
* @spec s12b1 range 3.2 3.4 unit=V
* @spec s12b2 range -0.02 0.02 unit=V
* @spec s13b0 range -0.02 0.02 unit=V
* @spec s13b1 range -0.02 0.02 unit=V
* @spec s13b2 range 3.2 3.4 unit=V
* @spec s14b0 range 3.2 3.4 unit=V
* @spec s14b1 range -0.02 0.02 unit=V
* @spec s14b2 range -0.02 0.02 unit=V
.control
set filetype=ascii
tran 100p 600n
meas tran s0b0 FIND v(q0) AT=15n
meas tran s0b1 FIND v(q1) AT=15n
meas tran s0b2 FIND v(q2) AT=15n
meas tran s1b0 FIND v(q0) AT=30n
meas tran s1b1 FIND v(q1) AT=30n
meas tran s1b2 FIND v(q2) AT=30n
meas tran s2b0 FIND v(q0) AT=70n
meas tran s2b1 FIND v(q1) AT=70n
meas tran s2b2 FIND v(q2) AT=70n
meas tran s3b0 FIND v(q0) AT=110n
meas tran s3b1 FIND v(q1) AT=110n
meas tran s3b2 FIND v(q2) AT=110n
meas tran s4b0 FIND v(q0) AT=150n
meas tran s4b1 FIND v(q1) AT=150n
meas tran s4b2 FIND v(q2) AT=150n
meas tran s5b0 FIND v(q0) AT=190n
meas tran s5b1 FIND v(q1) AT=190n
meas tran s5b2 FIND v(q2) AT=190n
meas tran s6b0 FIND v(q0) AT=230n
meas tran s6b1 FIND v(q1) AT=230n
meas tran s6b2 FIND v(q2) AT=230n
meas tran s7b0 FIND v(q0) AT=270n
meas tran s7b1 FIND v(q1) AT=270n
meas tran s7b2 FIND v(q2) AT=270n
meas tran s8b0 FIND v(q0) AT=310n
meas tran s8b1 FIND v(q1) AT=310n
meas tran s8b2 FIND v(q2) AT=310n
meas tran s9b0 FIND v(q0) AT=350n
meas tran s9b1 FIND v(q1) AT=350n
meas tran s9b2 FIND v(q2) AT=350n
meas tran s10b0 FIND v(q0) AT=390n
meas tran s10b1 FIND v(q1) AT=390n
meas tran s10b2 FIND v(q2) AT=390n
meas tran s11b0 FIND v(q0) AT=430n
meas tran s11b1 FIND v(q1) AT=430n
meas tran s11b2 FIND v(q2) AT=430n
meas tran s12b0 FIND v(q0) AT=470n
meas tran s12b1 FIND v(q1) AT=470n
meas tran s12b2 FIND v(q2) AT=470n
meas tran s13b0 FIND v(q0) AT=510n
meas tran s13b1 FIND v(q1) AT=510n
meas tran s13b2 FIND v(q2) AT=510n
meas tran s14b0 FIND v(q0) AT=550n
meas tran s14b1 FIND v(q1) AT=550n
meas tran s14b2 FIND v(q2) AT=550n
write out.raw v(q0) v(q1) v(q2) v(clk)
quit
.endc
.end
