CMOS two-stage scan register
.include "circuit.spice"
.include "models.spice"
VDD vdd 0 3.3
VCLK clk 0 PULSE(0 3.3 20n 100p 100p 19.9n 40n)
VSE se 0 PWL(0 3.3 39.5n 3.3 40.5n 3.3 79.5n 3.3 80.5n 3.3 119.5n 3.3 120.5n 3.3 159.5n 3.3 160.5n 3.3 199.5n 3.3 200.5n 0.0 239.5n 0.0 240.5n 0.0 279.5n 0.0 280.5n 0.0 319.5n 0.0 320.5n 3.3 359.5n 3.3 360.5n 3.3 399.5n 3.3 400.5n 3.3 439.5n 3.3 440.5n 3.3 480n 3.3)
VSI si 0 PWL(0 3.3 39.5n 3.3 40.5n 0.0 79.5n 0.0 80.5n 3.3 119.5n 3.3 120.5n 3.3 159.5n 3.3 160.5n 0.0 199.5n 0.0 200.5n 0.0 239.5n 0.0 240.5n 0.0 279.5n 0.0 280.5n 0.0 319.5n 0.0 320.5n 3.3 359.5n 3.3 360.5n 0.0 399.5n 0.0 400.5n 0.0 439.5n 0.0 440.5n 3.3 480n 3.3)
VD0 d0 0 PWL(0 0.0 39.5n 0.0 40.5n 3.3 79.5n 3.3 80.5n 0.0 119.5n 0.0 120.5n 3.3 159.5n 3.3 160.5n 3.3 199.5n 3.3 200.5n 0.0 239.5n 0.0 240.5n 3.3 279.5n 3.3 280.5n 3.3 319.5n 3.3 320.5n 0.0 359.5n 0.0 360.5n 3.3 399.5n 3.3 400.5n 3.3 439.5n 3.3 440.5n 0.0 480n 0.0)
VD1 d1 0 PWL(0 3.3 39.5n 3.3 40.5n 3.3 79.5n 3.3 80.5n 0.0 119.5n 0.0 120.5n 0.0 159.5n 0.0 160.5n 3.3 199.5n 3.3 200.5n 3.3 239.5n 3.3 240.5n 0.0 279.5n 0.0 280.5n 3.3 319.5n 3.3 320.5n 0.0 359.5n 0.0 360.5n 3.3 399.5n 3.3 400.5n 0.0 439.5n 0.0 440.5n 3.3 480n 3.3)
.ic v(q0)=0 v(q1)=0
XDUT vdd 0 d0 si d1 q0 q1 clk se astra_089_cmos_two_stage_scan_register
.temp 27
.options method=gear reltol=1e-5
* @spec c0b0 range 3.2 3.4 unit=V
* @spec c0b1 range -0.02 0.02 unit=V
* @spec c1b0 range -0.02 0.02 unit=V
* @spec c1b1 range 3.2 3.4 unit=V
* @spec c2b0 range 3.2 3.4 unit=V
* @spec c2b1 range -0.02 0.02 unit=V
* @spec c3b0 range 3.2 3.4 unit=V
* @spec c3b1 range 3.2 3.4 unit=V
* @spec c4b0 range -0.02 0.02 unit=V
* @spec c4b1 range 3.2 3.4 unit=V
* @spec c5b0 range -0.02 0.02 unit=V
* @spec c5b1 range 3.2 3.4 unit=V
* @spec c6b0 range 3.2 3.4 unit=V
* @spec c6b1 range -0.02 0.02 unit=V
* @spec c7b0 range 3.2 3.4 unit=V
* @spec c7b1 range 3.2 3.4 unit=V
* @spec c8b0 range 3.2 3.4 unit=V
* @spec c8b1 range 3.2 3.4 unit=V
* @spec c9b0 range -0.02 0.02 unit=V
* @spec c9b1 range 3.2 3.4 unit=V
* @spec c10b0 range -0.02 0.02 unit=V
* @spec c10b1 range -0.02 0.02 unit=V
* @spec c11b0 range 3.2 3.4 unit=V
* @spec c11b1 range -0.02 0.02 unit=V
.control
set filetype=ascii
tran 100p 480n
meas tran c0b0 FIND v(q0) AT=30n
meas tran c0b1 FIND v(q1) AT=30n
meas tran c1b0 FIND v(q0) AT=70n
meas tran c1b1 FIND v(q1) AT=70n
meas tran c2b0 FIND v(q0) AT=110n
meas tran c2b1 FIND v(q1) AT=110n
meas tran c3b0 FIND v(q0) AT=150n
meas tran c3b1 FIND v(q1) AT=150n
meas tran c4b0 FIND v(q0) AT=190n
meas tran c4b1 FIND v(q1) AT=190n
meas tran c5b0 FIND v(q0) AT=230n
meas tran c5b1 FIND v(q1) AT=230n
meas tran c6b0 FIND v(q0) AT=270n
meas tran c6b1 FIND v(q1) AT=270n
meas tran c7b0 FIND v(q0) AT=310n
meas tran c7b1 FIND v(q1) AT=310n
meas tran c8b0 FIND v(q0) AT=350n
meas tran c8b1 FIND v(q1) AT=350n
meas tran c9b0 FIND v(q0) AT=390n
meas tran c9b1 FIND v(q1) AT=390n
meas tran c10b0 FIND v(q0) AT=430n
meas tran c10b1 FIND v(q1) AT=430n
meas tran c11b0 FIND v(q0) AT=470n
meas tran c11b1 FIND v(q1) AT=470n
write out.raw v(q0) v(q1) v(se) v(si) v(clk)
quit
.endc
.end
