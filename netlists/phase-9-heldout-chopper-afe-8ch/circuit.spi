* Phase 9 second held-out topology-only fixture.
* Eight-channel chopper analog front end; no simulation/performance claim.

.subckt chopper_channel INP INN CLK CLKB VBIAS OUTP OUTN VDD VSS
XMSWP0 NXP CLK  INP VSS sky130_fd_pr__nfet_01v8 l=0.15 w=1.2
XMSWP1 NXP CLKB INN VSS sky130_fd_pr__nfet_01v8 l=0.15 w=1.2
XMSWN0 NXN CLK  INN VSS sky130_fd_pr__nfet_01v8 l=0.15 w=1.2
XMSWN1 NXN CLKB INP VSS sky130_fd_pr__nfet_01v8 l=0.15 w=1.2
XMINP  N1 NXP TAIL VSS sky130_fd_pr__nfet_01v8 l=0.5 w=4
XMINN  N2 NXN TAIL VSS sky130_fd_pr__nfet_01v8 l=0.5 w=4
XMTAIL TAIL VBIAS VSS VSS sky130_fd_pr__nfet_01v8 l=1 w=8
XMPC0  PC1 VBIAS VDD VDD sky130_fd_pr__pfet_01v8 l=0.5 w=6
XMPC1  PC2 VBIAS VDD VDD sky130_fd_pr__pfet_01v8 l=0.5 w=6
XMLOAD0 N1 N1 PC1 VDD sky130_fd_pr__pfet_01v8 l=0.5 w=6
XMLOAD1 N2 N1 PC2 VDD sky130_fd_pr__pfet_01v8 l=0.5 w=6
XMOUTP0 OUTP N1 VDD VDD sky130_fd_pr__pfet_01v8 l=0.3 w=10
XMOUTP1 OUTP N2 VSS VSS sky130_fd_pr__nfet_01v8 l=0.3 w=5
XMOUTN0 OUTN N2 VDD VDD sky130_fd_pr__pfet_01v8 l=0.3 w=10
XMOUTN1 OUTN N1 VSS VSS sky130_fd_pr__nfet_01v8 l=0.3 w=5
XMBIASP OUTP VBIAS VSS VSS sky130_fd_pr__nfet_01v8 l=1 w=2
XMBIASN OUTN VBIAS VSS VSS sky130_fd_pr__nfet_01v8 l=1 w=2
XMREF VBIAS VBIAS VSS VSS sky130_fd_pr__nfet_01v8 l=1 w=2
.ends chopper_channel

.subckt chopper_afe_8ch CLK CLKB VBIAS VDD VSS
+ INP0 INN0 OUTP0 OUTN0 INP1 INN1 OUTP1 OUTN1
+ INP2 INN2 OUTP2 OUTN2 INP3 INN3 OUTP3 OUTN3
+ INP4 INN4 OUTP4 OUTN4 INP5 INN5 OUTP5 OUTN5
+ INP6 INN6 OUTP6 OUTN6 INP7 INN7 OUTP7 OUTN7
XCH0 INP0 INN0 CLK CLKB VBIAS OUTP0 OUTN0 VDD VSS chopper_channel
XCH1 INP1 INN1 CLK CLKB VBIAS OUTP1 OUTN1 VDD VSS chopper_channel
XCH2 INP2 INN2 CLK CLKB VBIAS OUTP2 OUTN2 VDD VSS chopper_channel
XCH3 INP3 INN3 CLK CLKB VBIAS OUTP3 OUTN3 VDD VSS chopper_channel
XCH4 INP4 INN4 CLK CLKB VBIAS OUTP4 OUTN4 VDD VSS chopper_channel
XCH5 INP5 INN5 CLK CLKB VBIAS OUTP5 OUTN5 VDD VSS chopper_channel
XCH6 INP6 INN6 CLK CLKB VBIAS OUTP6 OUTN6 VDD VSS chopper_channel
XCH7 INP7 INN7 CLK CLKB VBIAS OUTP7 OUTN7 VDD VSS chopper_channel
.ends chopper_afe_8ch

.end
