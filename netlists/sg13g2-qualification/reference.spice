* Independently authored extended DUT, SI geometry. Port order is part of acceptance.
.subckt DUT vdd VSS out in sub rs rh collector base hvout hvin vh cl cv pc pb gateout
XN out in VSS sub sg13_lv_nmos w=2u l=500n ng=2 m=3
XP out in vdd vdd sg13_lv_pmos w=4u l=500n ng=2 m=1
XS rs VSS sub rsil w=1u l=10u m=2
XR out VSS sub rppd w=1u l=10u b=1 m=1
XH rh VSS sub rhigh w=1u l=10u b=0 m=2
XC out VSS cap_cmim w=7u l=7u m=2
XQ collector base VSS sub npn13G2 le=900n we=70n Nx=2
XHN hvout hvin VSS sub sg13_hv_nmos w=2u l=1u ng=2 m=3
XHP hvout hvin vh vh sg13_hv_pmos w=4u l=1u ng=2 m=1
XQL cl base VSS sub npn13G2l le=1u we=70n Nx=2
XQV cv base VSS sub npn13G2v le=1u we=120n Nx=3
XQP pc pb vdd pnpMPA a=1.44p p=5.4u m=2
XRF hvout VSS sub cap_rfcmim w=10u l=10u wfeed=5u m=2
XG gateout in in vdd VSS sg13g2_nand2_1
.ends DUT
