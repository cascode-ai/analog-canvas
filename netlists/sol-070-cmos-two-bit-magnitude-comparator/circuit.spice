.subckt sol_070_cmos_two_bit_magnitude_comparator vdd VSS eq gt lt a0 a1 b0 b1
CE eq VSS 100f
CG gt VSS 100f
CL lt VSS 100f
XM1 a0b a0 vdd vdd sky130_fd_pr__pfet_01v8 l=1 w=20 nf=1 m=1
XM10 a0b b0b e0 VSS sky130_fd_pr__nfet_01v8 l=1 w=10 nf=1 m=1
XM11 a0 b0b e0 vdd sky130_fd_pr__pfet_01v8 l=1 w=20 nf=1 m=1
XM12 a0 b0 e0 VSS sky130_fd_pr__nfet_01v8 l=1 w=10 nf=1 m=1
XM13 a1b b1 e1 vdd sky130_fd_pr__pfet_01v8 l=1 w=20 nf=1 m=1
XM14 a1b b1b e1 VSS sky130_fd_pr__nfet_01v8 l=1 w=10 nf=1 m=1
XM15 a1 b1b e1 vdd sky130_fd_pr__pfet_01v8 l=1 w=20 nf=1 m=1
XM16 a1 b1 e1 VSS sky130_fd_pr__nfet_01v8 l=1 w=10 nf=1 m=1
XM17 net0 e0 vdd vdd sky130_fd_pr__pfet_01v8 l=1 w=20 nf=1 m=1
XM18 net0 e1 vdd vdd sky130_fd_pr__pfet_01v8 l=1 w=20 nf=1 m=1
XM19 net0 e0 net1 VSS sky130_fd_pr__nfet_01v8 l=1 w=20 nf=1 m=1
XM2 a0b a0 VSS VSS sky130_fd_pr__nfet_01v8 l=1 w=10 nf=1 m=1
XM20 net1 e1 VSS VSS sky130_fd_pr__nfet_01v8 l=1 w=20 nf=1 m=1
XM21 eq net0 vdd vdd sky130_fd_pr__pfet_01v8 l=1 w=20 nf=1 m=1
XM22 eq net0 VSS VSS sky130_fd_pr__nfet_01v8 l=1 w=10 nf=1 m=1
XM23 g1b a1 vdd vdd sky130_fd_pr__pfet_01v8 l=1 w=20 nf=1 m=1
XM24 g1b b1b vdd vdd sky130_fd_pr__pfet_01v8 l=1 w=20 nf=1 m=1
XM25 g1b a1 net4 VSS sky130_fd_pr__nfet_01v8 l=1 w=20 nf=1 m=1
XM26 net4 b1b VSS VSS sky130_fd_pr__nfet_01v8 l=1 w=20 nf=1 m=1
XM27 g0b e1 vdd vdd sky130_fd_pr__pfet_01v8 l=1 w=20 nf=1 m=1
XM28 g0b a0 vdd vdd sky130_fd_pr__pfet_01v8 l=1 w=20 nf=1 m=1
XM29 g0b b0b vdd vdd sky130_fd_pr__pfet_01v8 l=1 w=20 nf=1 m=1
XM3 a1b a1 vdd vdd sky130_fd_pr__pfet_01v8 l=1 w=20 nf=1 m=1
XM30 g0b e1 net2 VSS sky130_fd_pr__nfet_01v8 l=1 w=30 nf=1 m=1
XM31 net2 a0 net3 VSS sky130_fd_pr__nfet_01v8 l=1 w=30 nf=1 m=1
XM32 net3 b0b VSS VSS sky130_fd_pr__nfet_01v8 l=1 w=30 nf=1 m=1
XM33 gt g1b vdd vdd sky130_fd_pr__pfet_01v8 l=1 w=20 nf=1 m=1
XM34 gt g0b vdd vdd sky130_fd_pr__pfet_01v8 l=1 w=20 nf=1 m=1
XM35 gt g1b net5 VSS sky130_fd_pr__nfet_01v8 l=1 w=20 nf=1 m=1
XM36 net5 g0b VSS VSS sky130_fd_pr__nfet_01v8 l=1 w=20 nf=1 m=1
XM37 l1b a1b vdd vdd sky130_fd_pr__pfet_01v8 l=1 w=20 nf=1 m=1
XM38 l1b b1 vdd vdd sky130_fd_pr__pfet_01v8 l=1 w=20 nf=1 m=1
XM39 l1b a1b net8 VSS sky130_fd_pr__nfet_01v8 l=1 w=20 nf=1 m=1
XM4 a1b a1 VSS VSS sky130_fd_pr__nfet_01v8 l=1 w=10 nf=1 m=1
XM40 net8 b1 VSS VSS sky130_fd_pr__nfet_01v8 l=1 w=20 nf=1 m=1
XM41 l0b e1 vdd vdd sky130_fd_pr__pfet_01v8 l=1 w=20 nf=1 m=1
XM42 l0b a0b vdd vdd sky130_fd_pr__pfet_01v8 l=1 w=20 nf=1 m=1
XM43 l0b b0 vdd vdd sky130_fd_pr__pfet_01v8 l=1 w=20 nf=1 m=1
XM44 l0b e1 net6 VSS sky130_fd_pr__nfet_01v8 l=1 w=30 nf=1 m=1
XM45 net6 a0b net7 VSS sky130_fd_pr__nfet_01v8 l=1 w=30 nf=1 m=1
XM46 net7 b0 VSS VSS sky130_fd_pr__nfet_01v8 l=1 w=30 nf=1 m=1
XM47 lt l1b vdd vdd sky130_fd_pr__pfet_01v8 l=1 w=20 nf=1 m=1
XM48 lt l0b vdd vdd sky130_fd_pr__pfet_01v8 l=1 w=20 nf=1 m=1
XM49 lt l1b net9 VSS sky130_fd_pr__nfet_01v8 l=1 w=20 nf=1 m=1
XM5 b0b b0 vdd vdd sky130_fd_pr__pfet_01v8 l=1 w=20 nf=1 m=1
XM50 net9 l0b VSS VSS sky130_fd_pr__nfet_01v8 l=1 w=20 nf=1 m=1
XM6 b0b b0 VSS VSS sky130_fd_pr__nfet_01v8 l=1 w=10 nf=1 m=1
XM7 b1b b1 vdd vdd sky130_fd_pr__pfet_01v8 l=1 w=20 nf=1 m=1
XM8 b1b b1 VSS VSS sky130_fd_pr__nfet_01v8 l=1 w=10 nf=1 m=1
XM9 a0b b0 e0 vdd sky130_fd_pr__pfet_01v8 l=1 w=20 nf=1 m=1
.ends sol_070_cmos_two_bit_magnitude_comparator
