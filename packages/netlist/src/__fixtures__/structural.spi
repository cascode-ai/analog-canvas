* Generated by Analog Canvas netlist-export/1.0
.global VDD

.subckt leaf d g s b params: scale=1
M1 d g s b nch l=60n w=2u
.ends leaf

.subckt top vin vout
C1 vin vout 2p
D1 vout 0 dmod area=2
I1 VDD 0 DC 10u
L1 vout 0 3n
Q1 vout vin 0 npnmod
R1 vin vout 10k temp=27
V1 vin 0 DC 1.2
X1 vout vin 0 0 leaf scale=2
.ends top
